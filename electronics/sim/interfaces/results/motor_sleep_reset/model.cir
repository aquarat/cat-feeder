Cat feeder interface study: motor_sleep_reset
Vdd rail 0 3.3
Rcarrier rail run 100k
R11 run 0 10000.0
.options reltol=1e-5 abstol=1e-12 vntol=1e-7
.control
set noaskquit
set wr_singlescale
set wr_vecnames
set numdgt=12
op
wrdata wave.dat v(run)
quit
.endc
.end
