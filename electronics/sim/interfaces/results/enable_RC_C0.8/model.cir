Cat feeder interface study: enable_RC_C0.8
Vdd rail 0 PULSE(0 3.3 1m 1n 1n 100m 200m)
R1 rail en 10000.0
C5 en 0 8e-07
.options reltol=1e-5 abstol=1e-12 vntol=1e-7
.control
set noaskquit
set wr_singlescale
set wr_vecnames
set numdgt=12
tran 1e-05 0.04 0 1e-05
wrdata wave.dat v(en)
quit
.endc
.end
