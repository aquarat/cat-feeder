Cat feeder interface study: adc_20V_0.99_0.99
Vbus bus 0 20
Rtop bus adc 99000.0
Rbottom adc 0 9900.0
Cfilter adc 0 1.0000000000000001e-07
.options reltol=1e-5 abstol=1e-12 vntol=1e-7
.control
set noaskquit
set wr_singlescale
set wr_vecnames
set numdgt=12
op
wrdata wave.dat v(adc)
quit
.endc
.end
