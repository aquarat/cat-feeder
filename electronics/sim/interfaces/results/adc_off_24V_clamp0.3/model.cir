Cat feeder interface study: adc_off_24V_clamp0.3
Vbus bus 0 24
Rtop bus adc 100000.0
Rbottom adc 0 10000.0
Bclamp adc clamp_return I=max((v(adc)-0.3)/10,0)
Vmonitor clamp_return 0 0

.options reltol=1e-5 abstol=1e-12 vntol=1e-7
.control
set noaskquit
set wr_singlescale
set wr_vecnames
set numdgt=12
op
wrdata wave.dat v(adc) i(Vmonitor)
quit
.endc
.end
