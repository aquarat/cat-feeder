Cat feeder interface study: uart_dps_off_0.3_True
Vtx source 0 3.3
Rdriver source output 20
R15 output dps_rx 1000.0
Bclamp dps_rx clamp_return I=max((v(dps_rx)-0.3)/10,0)
Vmonitor clamp_return 0 0
Rleak dps_rx 0 1e9

.options reltol=1e-5 abstol=1e-12 vntol=1e-7
.control
set noaskquit
set wr_singlescale
set wr_vecnames
set numdgt=12
op
wrdata wave.dat v(dps_rx) i(Vmonitor)
quit
.endc
.end
