Cat feeder interface study: bias_R12
Vpull pull 0 0
Rbias pull signal 101000.0
Ileak signal 0 -1e-06
.options reltol=1e-5 abstol=1e-12 vntol=1e-7
.control
set noaskquit
set wr_singlescale
set wr_vecnames
set numdgt=12
op
wrdata wave.dat v(signal)
quit
.endc
.end
